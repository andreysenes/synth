* VOZ-9 — 04_shape.cir
* Ge clipper (1N34A stand-in for MP20) + SHAPE pot via J1

* voz9_shape
.include lib.inc
.include painel_state.inc
.include painel.cir

Xrails V9 V5 VEE 4V5 1V8 rails

* SHAPE é divisor: CCW = GND (quase limpo), CW = áudio, cursor → 10k → clip.
Vin sig 0 SIN(4.5 2 1k)
Rdrive sig j1_10 10
Rj1_8 j1_8 0 1
* Per esquema: SHAPE wiper -- 10k -- clip node -- MP20 to GND
Rseries j1_9 clip 10k
Dge clip 0 D1N34A
Cout clip filt 100n
Rfilt filt 0 100k

.control
set noaskquit
tran 10u 5m
print V(sig) V(clip) V(filt)
echo SHAPE_DONE
quit
.endc
.end
